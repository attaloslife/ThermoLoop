.title ThermoLoop Fan_PWM
.include "spice/pwm.inc"
.tran 50n 200u
.end
